* Test 3: Mixed linear and nonlinear circuit
* Validates D, Q, M devices, model names, optional terminals, and all commands

VCC vcc 0 5
VEE vee 0 -5
VIN in 0 0.7

* Input bias network
RIN in base 10k
RB base 0 100k
RE emit 0 2.2k
I1 0 base 100u

* BJT common-emitter stage (C-B-E only)
Q1 coll base emit NPN

* BJT with explicit substrate terminal (C-B-E-S)
Q2 vcc base emit sub PNP

* Collector network
RC vcc coll 4.7k
RCE coll out 1Meg

* Diode clamp (with and without model)
D1 vcc coll
D2 coll vee DMOD

* PMOS with explicit bulk terminal
M1 out gate src vcc PMOS

* NMOS with implicit bulk (= source)
M2 out gate 0 NMOS

* Passive storage and load
C1 coll 0 1n
L1 out 0 10u
RLOAD out 0 1Meg
COUT out 0 100p

.OP
.PRINT
