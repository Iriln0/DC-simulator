* Test 3: Mixed linear and nonlinear circuit (ngspice-compatible)
* Validates D, Q, M, model names, optional substrate/bulk, .OP and .PRINT

.model DMOD D ( Is=1e-14 N=1 )
.model NPN NPN ( Is=1e-16 Bf=100 Br=1 Vaf=100 )
.model PNP PNP ( Is=1e-16 Bf=50 Br=2 Vaf=80 )
.model NMOS NMOS ( Vto=0.7 Kp=20u Lambda=0.02 )
.model PMOS PMOS ( Vto=-0.7 Kp=10u Lambda=0.02 )

VCC vcc 0 5

* Mid-rail bias for BJT base and MOS gates
R1 vcc bias 10k
R2 bias 0 10k

* NPN common-emitter (3-terminal)
RE emit 0 330
RC vcc coll 2.2k
Q1 coll bias emit NPN

* PNP high-side with substrate at vcc (4-terminal C-B-E-S)
Q2 coll bias vcc sub PNP

* Diode clamps (named models)
D1 vcc coll DMOD
D2 coll 0 DMOD

* CMOS push-pull output (explicit bulk nodes)
M1 out bias 0 0 NMOS
M2 out bias vcc vcc PMOS
RDR vcc out 4.7k
Rsub sub vcc 10Meg

* Storage and load
C1 coll 0 100p
L1 out 0 1u
RLOAD out 0 10k

.OP
.PRINT
